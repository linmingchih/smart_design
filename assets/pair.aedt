# Ansys Electronics Desktop project, version 2024.1
materials:
  vacuum: permittivity=1
  copper: permeability=0.999991 conductivity=58000000

design HFSSDesign1 (HFSS, HFSS Terminal Network, model units mm)
variables:
  length = 7.3946667mm
  width = 2.1393333mm
  thickness = 0.21513333mm
  gap = 2mm
geometry:
  Box1 [copper] = box(corner=(0mm, 0mm, 0mm), size=(length, width, thickness))
  Box1_1 [copper] = Box1.duplicate_along_line(step=(0mm, 0mm, gap), total=2)
  RadiatingSurface [vacuum] = region(absolute_offset=1mm on all sides)
  Box1_ObjectFromEdge1 = object_from(Box1.edge(3 of 12))
  Box1_1_ObjectFromEdge1 = object_from(Box1_1.edge(at (0, 1.06967, 2)))
  Box1_ObjectFromEdge1.connect(Box1_1_ObjectFromEdge1)
  Box1_1_ObjectFromEdge2 = object_from(Box1_1.edge(at (7.39467, 1.06967, 2)))
  Box1_ObjectFromEdge2 = object_from(Box1.edge(1 of 12))
  Box1_1_ObjectFromEdge2.connect(Box1_ObjectFromEdge2)
boundaries and excitations:
  Open1: Radiation Objects=RadiatingSurface
  Box1_1_T1: Terminal port=1 Edges=Box1_1.edge(at (0, 1.06967, 2)) TerminalResistance=50ohm
  Box1_1_T2: Terminal port=2 Edges=Box1_1.edge(at (7.39467, 1.06967, 2)) TerminalResistance=50ohm
  1: Lumped Port Faces=Box1_ObjectFromEdge1.face LumpedPortType=Terminal Impedance=50ohm
  2: Lumped Port Faces=Box1_1_ObjectFromEdge2.face LumpedPortType=Terminal Impedance=50ohm
  reference conductors: Box1
setups:
  Setup1: HfssDriven Frequency=5GHz MaxDeltaS=0.02 MaximumPasses=6 MinimumPasses=1 MinimumConvergedPasses=1 PercentRefinement=30 BasisOrder=1 PortAccuracy=2 DrivenSolverType="Direct Solver"
    sweep Sweep: 0.1GHz to 7.5GHz, 401 points; Type=Interpolating InterpTolerance=0.5 InterpMaxSolns=250 PassivityErrorTolerance=0.0001
source amplitudes:
  1:1: 1V 0deg
  2:1: 0V 0deg
radiation setups:
  3D: Infinite Sphere Theta=0deg..180deg step 2deg Phi=-180deg..180deg step 2deg
  Elevation: Infinite Sphere Theta=-180deg..180deg step 1deg Phi=0deg..90deg step 90deg
  Azimuth: Infinite Sphere Theta=90deg..90deg step 0deg Phi=-180deg..180deg step 1deg
reports:
  Terminal S Parameter Plot 1: dB(St(Box1_1_T1,Box1_1_T1)) vs Freq on Setup1 : Sweep
  Terminal S Parameter Plot 2: dB(St(Box1_1_T2,Box1_1_T1)) vs Freq on Setup1 : Sweep
